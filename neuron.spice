* Analog Neuron Subcircuit — Gilbert Cell Implementation
*
* Neuron interface:
*   VIN1, VIN2  — Input terminals. Accept voltage, produce gradient current.
*   OUT         — Output terminal. Drives V_out = W1*VIN1 + W2*VIN2.
*                 Low impedance (~100 ohm); voltage stable under load.
*                 In a chain, current sinking into OUT from downstream
*                 gradient cells is the error signal for backpropagation.
*   ERR         — Error signal input (voltage). Drives the backward path.
*                 In testbench: explicit voltage source.
*                 In a chain: derived from current sensed at OUT.
*   W1_EXT, W2_EXT — Weight cap nodes for programming and monitoring.
*
* Forward path:  V_out = W1*VIN1 + W2*VIN2
* Backward path: I(VIN_i) = K * W_i * ERR  (~1 uA/V^2)
*
* Sign convention:
*   Positive gradient = positive current sinking from upstream output
*   into this neuron's input terminal.
*   Positive ERR + positive W -> positive current into VIN (negative feedback).
*
* VCC=+5V, VEE=-5V, signal range: +/-1V, Z_out ~ 100 ohm

.include models.spice

***********************************************************************
* BACKWARD MULTIPLIER — DC-coupled
*
* Gilbert cell analog multiplier: I_out = K * GAIN * SIGNAL
* Output current injected into INJECT node through 960k resistor.
* DC-compatible: the voltage source at INJECT absorbs any DC offset.
* Mirror output (outn_bk) drives R_inject directly (no buffering needed
* since 960k is negligible load vs R_trans 1.1k).
*
* Used inside neuron as gradient cell:
*   GAIN=weight, SIGNAL=error, INJECT=VIN terminal
*
* Ports:
*   GAIN    — Multiplier input A. Fed through 15:1 divider to upper quad.
*   SIGNAL  — Multiplier input B. Drives lower differential pair vs GND.
*   INJECT  — Output. Result current ~1 uA/V^2 injected here via R_inject.
*   VCC/VEE — Power rails.
*   WBIAS   — Reference for 15:1 divider midpoint.
*   TAILREF — Mirror reference for 2mA tail current source.
*   REF3    — Reference for transimpedance resistor.
***********************************************************************

.subckt bk_mult GAIN SIGNAL INJECT VCC VEE WBIAS TAILREF REF3

* 15:1 symmetric divider for GAIN
* Keeps upper quad differential input in linear tanh region
R_dp_top GAIN wp_bk 14k
R_dp_bot wp_bk WBIAS 1k
R_dn_gnd gnd_bk_w 0 1
R_dn_top gnd_bk_w wn_bk 14k
R_dn_bot wn_bk WBIAS 1k

* Tail current source (2mA, mirrored from TAILREF)
Q_tail_bk tail_bk TAILREF VEE NPN_AN

* Lower differential pair (SIGNAL vs GND)
* Degenerated by Re=1k for linearity up to ~1V
Q_a c_a SIGNAL e_a NPN_AN
Q_b c_b gnd_bk_s e_b NPN_AN
R_gnd_bk gnd_bk_s 0 1
Re_a e_a tail_bk 1k
Re_b e_b tail_bk 1k

* Upper quad (cross-coupled Gilbert topology)
* Multiplies lower pair current split by GAIN-derived differential
Q_q3 outp_bk wp_bk c_a NPN_AN
Q_q4 outn_bk wn_bk c_a NPN_AN
Q_q5 outp_bk wn_bk c_b NPN_AN
Q_q6 outn_bk wp_bk c_b NPN_AN

* PNP current mirror load (differential to single-ended)
Q_m1_bk outp_bk outp_bk VCC PNP_AN
Q_m2_bk outn_bk outp_bk VCC PNP_AN

* Transimpedance: convert mirror output current to voltage
R_trans_bk outn_bk REF3 1.1k

* Output: inject current into INJECT node
* I_inject = V(outn_bk) / 960k ~ K * GAIN * SIGNAL
* (960k = 700k / 0.725 to compensate for removed EF+divider gain)
R_inject outn_bk INJECT 960k

.ends bk_mult

***********************************************************************
* BACKWARD MULTIPLIER — AC-coupled
*
* Same as bk_mult but with 1uF coupling cap before R_inject.
* Blocks DC offset that would drift weight capacitors.
* For use when INJECT is a weight capacitor node.
* Mirror output drives coupling cap directly (no EF buffer needed).
*
* Requires .ic V(x.bk_ac)=V_target_init to pre-charge coupling cap.
***********************************************************************

.subckt bk_mult_ac GAIN SIGNAL INJECT VCC VEE WBIAS TAILREF REF3

* 15:1 symmetric divider for GAIN
R_dp_top GAIN wp_bk 14k
R_dp_bot wp_bk WBIAS 1k
R_dn_gnd gnd_bk_w 0 1
R_dn_top gnd_bk_w wn_bk 14k
R_dn_bot wn_bk WBIAS 1k

* Tail current source (2mA, mirrored from TAILREF)
Q_tail_bk tail_bk TAILREF VEE NPN_AN

* Lower differential pair (SIGNAL vs GND)
Q_a c_a SIGNAL e_a NPN_AN
Q_b c_b gnd_bk_s e_b NPN_AN
R_gnd_bk gnd_bk_s 0 1
Re_a e_a tail_bk 1k
Re_b e_b tail_bk 1k

* Upper quad (cross-coupled Gilbert topology)
Q_q3 outp_bk wp_bk c_a NPN_AN
Q_q4 outn_bk wn_bk c_a NPN_AN
Q_q5 outp_bk wn_bk c_b NPN_AN
Q_q6 outn_bk wp_bk c_b NPN_AN

* PNP current mirror load
Q_m1_bk outp_bk outp_bk VCC PNP_AN
Q_m2_bk outn_bk outp_bk VCC PNP_AN

* Transimpedance
R_trans_bk outn_bk REF3 1.1k

* AC coupling + output injection
* C_couple blocks DC offset; passes signal (tau = 0.96s >> pulse width)
* Pre-charge with .ic V(bk_ac) = V(INJECT_init)
* (960k = 700k / 0.725 to compensate for removed EF+divider gain)
C_couple outn_bk bk_ac 1u
R_inject bk_ac INJECT 960k

.ends bk_mult_ac

***********************************************************************
* NEURON SUBCIRCUIT
*
* Ports:
*   VIN1, VIN2 — Input terminals (voltage in, gradient current out)
*   OUT        — Output terminal (voltage out, error current in)
*   VCC, VEE   — Power rails (+5V, -5V)
*   W1_EXT     — Weight 1 capacitor node
*   W2_EXT     — Weight 2 capacitor node
*   ERR        — Error signal voltage input
*
* Forward:  V(OUT) = W1 * V(VIN1) + W2 * V(VIN2)
* Backward: I(VIN_i) = K * W_i * V(ERR),  K ~ 1 uA/V^2
*           Positive error + positive weight -> positive current into VIN
***********************************************************************

.subckt neuron VIN1 VIN2 OUT VCC VEE W1_EXT W2_EXT ERR

* ==================================================================
* WEIGHT STORAGE
* 100nF caps hold weights; 100M bleed resistors for DC bias path.
* E-element buffers prevent forward/backward dividers from loading caps.
* ==================================================================
C_w1 W1_EXT 0 100n
R_bleed1 W1_EXT 0 100MEG
C_w2 W2_EXT 0 100n
R_bleed2 W2_EXT 0 100MEG

E_w1_buf w1_buf 0 W1_EXT 0 1.0
E_w2_buf w2_buf 0 W2_EXT 0 1.0

* ==================================================================
* FORWARD BIAS
* Independent bias network for forward Gilbert cells.
* ==================================================================

* Weight divider reference (~2V for upper quad operating point)
R_fwd_bias_top VCC fwd_bias_raw 4.7k
R_fwd_bias_bot fwd_bias_raw VEE 15k
Q_fwd_bias_buf VCC fwd_bias_raw fwd_w_bias NPN_AN
R_fwd_bias_load fwd_w_bias VEE 20k

* Tail current reference (2mA per channel)
R_fwd_tail_top VCC fwd_tail_ref 4.65k
Q_fwd_tail_ref fwd_tail_ref fwd_tail_ref VEE NPN_AN

* Transimpedance reference (~2.6V)
R_fwd_ref3_top VCC fwd_ref3_raw 2.6k
R_fwd_ref3_bot fwd_ref3_raw VEE 13k
Q_fwd_ref3_buf VCC fwd_ref3_raw fwd_ref3 NPN_AN
R_fwd_ref3_load fwd_ref3 VEE 10k

* ==================================================================
* FORWARD CHANNEL 1: W1 * VIN1
* NPN Gilbert cell: lower pair on VIN1, upper quad on weight W1.
* ==================================================================

* 15:1 symmetric weight divider (keeps upper quad in linear region)
R_div1_p_top w1_buf wp1 14k
R_div1_p_bot wp1 fwd_w_bias 1k
R_div1_n_gnd gnd1_w 0 1
R_div1_n_top gnd1_w wn1 14k
R_div1_n_bot wn1 fwd_w_bias 1k

* Tail current source (mirrored from fwd_tail_ref)
Q_tail1 tail1 fwd_tail_ref VEE NPN_AN

* Lower differential pair: VIN1 vs GND, degenerated by Re=1k
Q1_a c1_a VIN1 e1_a NPN_AN
Q1_b c1_b gnd1_s e1_b NPN_AN
R_gnd1 gnd1_s 0 1
Re1_a e1_a tail1 1k
Re1_b e1_b tail1 1k

* Upper quad: cross-coupled, driven by weight divider
Q1_q3 outp wp1 c1_a NPN_AN
Q1_q4 outn wn1 c1_a NPN_AN
Q1_q5 outp wn1 c1_b NPN_AN
Q1_q6 outn wp1 c1_b NPN_AN

* ==================================================================
* FORWARD CHANNEL 2: W2 * VIN2
* Same topology as channel 1, shares PNP mirror load.
* ==================================================================

R_div2_p_top w2_buf wp2 14k
R_div2_p_bot wp2 fwd_w_bias 1k
R_div2_n_gnd gnd2_w 0 1
R_div2_n_top gnd2_w wn2 14k
R_div2_n_bot wn2 fwd_w_bias 1k

Q_tail2 tail2 fwd_tail_ref VEE NPN_AN

Q2_a c2_a VIN2 e2_a NPN_AN
Q2_b c2_b gnd2_s e2_b NPN_AN
R_gnd2 gnd2_s 0 1
Re2_a e2_a tail2 1k
Re2_b e2_b tail2 1k

Q2_q3 outp wp2 c2_a NPN_AN
Q2_q4 outn wn2 c2_a NPN_AN
Q2_q5 outp wn2 c2_b NPN_AN
Q2_q6 outn wp2 c2_b NPN_AN

* ==================================================================
* PNP CURRENT MIRROR LOAD (shared by both forward channels)
* Converts differential current to single-ended output.
* ==================================================================
Q_m1 outp outp VCC PNP_AN
Q_m2 outn outp VCC PNP_AN

* ==================================================================
* FORWARD OUTPUT STAGE
* Low-impedance voltage output: R_trans -> EF1 -> level shift ->
* current source -> EF2 -> R_out(80 ohm).
* Z_out ~ 100 ohm. Voltage stable under gradient current load.
* ==================================================================

* Transimpedance: convert mirror current to voltage
R_trans outn fwd_ref3 1.1k

* First emitter follower
Q_ef1 VCC outn ef1_e NPN_AN
R_level ef1_e level_node 1.1k

* Current source for level shifting
R_cs_ref VCC cs_ref_c 9.3k
Q_cs_ref cs_ref_c cs_ref_c VEE NPN_AN
Q_cs cs_col cs_ref_c VEE NPN_AN
R_cs_dummy level_node cs_col 1

* Second emitter follower + output resistor
Q_ef2 VCC level_node ef2_e NPN_AN
R_ef2_load ef2_e VEE 2.15k
R_out ef2_e OUT 80

* ==================================================================
* BACKWARD BIAS
* Separate bias network prevents backward path from coupling into
* the forward path. Same topology, independent nodes.
* ==================================================================

R_bk_bias_top VCC bk_bias_raw 4.7k
R_bk_bias_bot bk_bias_raw VEE 15k
Q_bk_bias_buf VCC bk_bias_raw bk_w_bias NPN_AN
R_bk_bias_load bk_w_bias VEE 20k

R_bk_tail_top VCC bk_tail_ref 4.65k
Q_bk_tail_ref bk_tail_ref bk_tail_ref VEE NPN_AN

R_bk_ref3_top VCC bk_ref3_raw 2.6k
R_bk_ref3_bot bk_ref3_raw VEE 13k
Q_bk_ref3_buf VCC bk_ref3_raw bk_ref3 NPN_AN
R_bk_ref3_load bk_ref3 VEE 10k

* ==================================================================
* BACKWARD GRADIENT CELLS
* Generate gradient current at each input terminal:
*   I(VIN_i) = K * W_i * ERR,  K ~ 1 uA/V^2
*
* Each cell is a bk_mult with:
*   GAIN   = W_i (weight buffer)
*   SIGNAL = ERR (error voltage)
*   INJECT = VIN_i (gradient current sinks into input terminal)
*
* Positive ERR * positive W -> positive current into VIN
* (current sinks from upstream output through wire into this input)
* ==================================================================
X_grad1 w1_buf ERR VIN1 VCC VEE bk_w_bias bk_tail_ref bk_ref3 bk_mult
X_grad2 w2_buf ERR VIN2 VCC VEE bk_w_bias bk_tail_ref bk_ref3 bk_mult

.ends neuron
