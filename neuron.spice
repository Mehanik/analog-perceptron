* Analog Neuron Subcircuit — Gilbert Cell Implementation
*
* Neuron interface:
*   VIN1, VIN2  — Input terminals. Accept voltage, produce gradient current.
*   OUT         — Output terminal. Drives V_out = W1*VIN1 + W2*VIN2.
*                 Low impedance (~100 ohm); voltage stable under load.
*                 In a chain, current sinking into OUT from downstream
*                 gradient cells is the error signal for backpropagation.
*   ERR         — Error signal input (voltage). Drives the backward path.
*                 In testbench: explicit voltage source.
*                 In a chain: derived from current sensed at OUT.
*   W1_EXT, W2_EXT — Weight cap nodes for programming and monitoring.
*
* Forward path:  V_out = W1*VIN1 + W2*VIN2
* Backward path: I(VIN_i) = K * W_i * ERR  (~1 uA/V^2)
*
* Sign convention:
*   Positive gradient = positive current sinking from upstream output
*   into this neuron's input terminal.
*   Positive ERR + positive W -> positive current into VIN (negative feedback).
*
* VCC=+5V, VEE=-5V, signal range: +/-1V, Z_out ~ 300 ohm

.include models.spice

***********************************************************************
* BACKWARD MULTIPLIER — voltage-output Gilbert cell
*
* Gilbert cell analog multiplier: V(OUT) = f(GAIN, SIGNAL)
* Outputs a voltage proportional to GAIN * SIGNAL at the OUT port.
* The caller adds external R_inject (960k) and optional coupling cap
* to connect to the target node (VIN terminal or weight capacitor).
*
* Used inside neuron as gradient cell (DC-coupled):
*   X_grad ... bk_mult  +  R_inject OUT TARGET 960k
*
* Used at testbench level for weight update (AC-coupled):
*   X_bk ... bk_mult  +  C_couple OUT mid 1u  +  R_inject mid TARGET 960k
*   (.ic pre-charges C_couple so R_inject sees no DC)
*
* Ports:
*   GAIN    — Multiplier input A. Fed through 15:1 divider to upper quad.
*   SIGNAL  — Multiplier input B. Drives lower differential pair vs GND.
*   OUT     — Voltage output (mirror node after R_trans).
*   VCC/VEE — Power rails.
*   WBIAS   — Reference for 15:1 divider midpoint.
*   TAILREF — Mirror reference for 2mA tail current source.
*   REF3    — Reference for transimpedance resistor.
***********************************************************************

.subckt bk_mult GAIN SIGNAL OUT VCC VEE WBIAS TAILREF REF3

* 15:1 symmetric divider for GAIN
* Keeps upper quad differential input in linear tanh region
R_dp_top GAIN wp_bk 14k
R_dp_bot wp_bk WBIAS 1k
R_dn_gnd gnd_bk_w 0 1
R_dn_top gnd_bk_w wn_bk 14k
R_dn_bot wn_bk WBIAS 1k

* Tail current source (2mA, mirrored from TAILREF)
Q_tail_bk tail_bk TAILREF VEE NPN_AN

* Lower differential pair (SIGNAL vs GND)
* Degenerated by Re=1k for linearity up to ~1V
Q_a c_a SIGNAL e_a NPN_AN
Q_b c_b gnd_bk_s e_b NPN_AN
R_gnd_bk gnd_bk_s 0 1
Re_a e_a tail_bk 1k
Re_b e_b tail_bk 1k

* Upper quad (cross-coupled Gilbert topology)
* Multiplies lower pair current split by GAIN-derived differential
Q_q3 outp_bk wp_bk c_a NPN_AN
Q_q4 OUT wn_bk c_a NPN_AN
Q_q5 outp_bk wn_bk c_b NPN_AN
Q_q6 OUT wp_bk c_b NPN_AN

* PNP current mirror load (differential to single-ended)
Q_m1_bk outp_bk outp_bk VCC PNP_AN
Q_m2_bk OUT outp_bk VCC PNP_AN

* Transimpedance: convert mirror output current to voltage
R_trans_bk OUT REF3 1.1k

.ends bk_mult

***********************************************************************
* NEURON SUBCIRCUIT
*
* Ports:
*   VIN1, VIN2 — Input terminals (voltage in, gradient current out)
*   OUT        — Output terminal (voltage out, error current in)
*   VCC, VEE   — Power rails (+5V, -5V)
*   W1_EXT     — Weight 1 capacitor node
*   W2_EXT     — Weight 2 capacitor node
*   ERR        — Error signal voltage input
*
* Forward:  V(OUT) = W1 * V(VIN1) + W2 * V(VIN2)
* Backward: I(VIN_i) = K * W_i * V(ERR),  K ~ 1 uA/V^2
*           Positive error + positive weight -> positive current into VIN
***********************************************************************

***********************************************************************
* NEURON CHANNEL — one input channel (forward Gilbert cell + gradient)
*
* Contains per-channel components:
*   - Weight storage (cap + bleed + buffer)
*   - Forward Gilbert cell (15:1 divider, tail, lower pair, upper quad)
*   - Gradient cell (bk_mult + R_inject)
*
* Ports:
*   VIN     — Input terminal (voltage in, gradient current out)
*   OUTP    — Forward mirror positive rail (shared across channels)
*   OUTN    — Forward mirror negative rail (shared across channels)
*   W_EXT   — Weight capacitor node for programming/monitoring
*   ERR     — Error signal voltage input
*   VCC/VEE — Power rails
*   WBIAS   — Weight divider reference
*   TAILREF — Tail current mirror reference
*   REF3    — Transimpedance reference
***********************************************************************

.subckt neuron_ch VIN OUTP OUTN W_EXT ERR VCC VEE WBIAS TAILREF REF3

* Weight storage
C_w W_EXT 0 100n
R_bleed W_EXT 0 100MEG
E_w_buf w_buf 0 W_EXT 0 1.0

* 15:1 symmetric weight divider (keeps upper quad in linear region)
R_div_p_top w_buf wp 14k
R_div_p_bot wp WBIAS 1k
R_div_n_gnd gnd_w 0 1
R_div_n_top gnd_w wn 14k
R_div_n_bot wn WBIAS 1k

* Tail current source (mirrored from TAILREF)
Q_tail tail TAILREF VEE NPN_AN

* Lower differential pair: VIN vs GND, degenerated by Re=1k
Q_a c_a VIN e_a NPN_AN
Q_b c_b gnd_s e_b NPN_AN
R_gnd gnd_s 0 1
Re_a e_a tail 1k
Re_b e_b tail 1k

* Upper quad: cross-coupled, driven by weight divider
Q_q3 OUTP wp c_a NPN_AN
Q_q4 OUTN wn c_a NPN_AN
Q_q5 OUTP wn c_b NPN_AN
Q_q6 OUTN wp c_b NPN_AN

* Gradient cell: I(VIN) = K * W * ERR
X_grad w_buf ERR grad_out VCC VEE WBIAS TAILREF REF3 bk_mult
R_grad_inject grad_out VIN 960k

.ends neuron_ch

***********************************************************************
* NEURON SUBCIRCUIT
*
* Ports:
*   VIN1, VIN2 — Input terminals (voltage in, gradient current out)
*   OUT        — Output terminal (voltage out, error current in)
*   VCC, VEE   — Power rails (+5V, -5V)
*   W1_EXT     — Weight 1 capacitor node
*   W2_EXT     — Weight 2 capacitor node
*   ERR        — Error signal voltage input
*
* Forward:  V(OUT) = W1 * V(VIN1) + W2 * V(VIN2)
* Backward: I(VIN_i) = K * W_i * V(ERR),  K ~ 1 uA/V^2
*           Positive error + positive weight -> positive current into VIN
***********************************************************************

.subckt neuron VIN1 VIN2 OUT VCC VEE W1_EXT W2_EXT ERR

* ==================================================================
* SHARED BIAS (forward + backward)
* w_bias and tail_ref are shared between forward and backward paths.
* Multiple mirrors from one tail_ref is standard; w_bias is pure DC.
* ref3 is shared: coupling ~14mV at ERR=1V (forward slope/gradient/Z_out
* unaffected). Verified by test_ref3_sharing.spice.
* ==================================================================

* Weight divider reference (~2V for upper quad operating point)
R_bias_top VCC bias_raw 4.7k
R_bias_bot bias_raw VEE 15k
Q_bias_buf VCC bias_raw w_bias NPN_AN
R_bias_load w_bias VEE 20k

* Tail current reference (2mA per channel)
R_tail_top VCC tail_ref 4.65k
Q_tail_ref tail_ref tail_ref VEE NPN_AN

* Transimpedance reference (~2.6V) — shared by forward and backward paths
R_ref3_top VCC ref3_raw 2.6k
R_ref3_bot ref3_raw VEE 13k
Q_ref3_buf VCC ref3_raw ref3 NPN_AN
R_ref3_load ref3 VEE 10k

* ==================================================================
* INPUT CHANNELS
* ==================================================================
X_ch1 VIN1 outp outn W1_EXT ERR VCC VEE w_bias tail_ref ref3 neuron_ch
X_ch2 VIN2 outp outn W2_EXT ERR VCC VEE w_bias tail_ref ref3 neuron_ch

* ==================================================================
* PNP CURRENT MIRROR LOAD (shared by both forward channels)
* Converts differential current to single-ended output.
* ==================================================================
Q_m1 outp outp VCC PNP_AN
Q_m2 outn outp VCC PNP_AN

* ==================================================================
* FORWARD OUTPUT STAGE
* Low-impedance voltage output: R_trans -> EF -> resistive divider
* level shift -> R_out.
* Z_out ~ 300 ohm. Voltage stable under gradient current load.
* ==================================================================

* Transimpedance: convert mirror current to voltage
* (increased from 1.1k to compensate for divider attenuation)
R_trans outn ref3 1.55k

* Emitter follower
Q_ef1 VCC outn ef1_e NPN_AN

* Resistive divider level shift: sets out_mid ~ 0V when inputs are zero
* ef1_e ~ ref3 - Vbe ~ 2.63 - 0.7 = 1.93V at quiescent
* out_mid = VEE + (ef1_e - VEE) * R_bot/(R_top + R_bot)
* For out_mid = 0: R_bot/(R_top+R_bot) = 5/6.93 = 0.722
R_top ef1_e out_mid 370
R_bot out_mid VEE 1k

* Output resistor
R_out out_mid OUT 30

.ends neuron
