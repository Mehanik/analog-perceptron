* Ref3 Sharing Validation Tests
* Verifies that sharing transimpedance reference (ref3) between forward
* and backward paths does not introduce unacceptable coupling.
*
* Tests:
*   1. Forward slope (DC sweep VIN1)
*   2. Forward/backward coupling (I_err=0 vs I_err=1uA)
*   3. Gradient accuracy (I_err sweep, gradient current extraction)
*   4. Shared ref3 operating point
*   5. Output impedance spot check

.include testbench.spice

.control

set noaskquit

* =====================================================================
* Test 1: Forward Slope
* DC sweep VIN1, measure slope. Should match known value ~0.616.
* PASS if within 1%.
* =====================================================================
echo ""
echo "============================================"
echo "Test 1: Forward Slope (ref3 shared)"
echo "============================================"
alter Vin1 DC = 0
alter Vin2 DC = 0.3
alter I_err DC = 0
dc Vin1 -1.1 1.1 0.02
meas DC vout_p02  FIND V(vout) AT=0.02
meas DC vout_n02  FIND V(vout) AT=-0.02
let slope = (vout_p02 - vout_n02) / 0.04
echo "Forward slope near VIN1=0 (expect ~0.623):"
print slope
let slope_err = abs(slope - 0.623) / 0.623
echo "Relative error vs 0.623:"
print slope_err
if slope_err < 0.02
  echo ">>> PASS: Forward slope within 2%"
else
  echo ">>> FAIL: Forward slope deviation > 2%"
end

* =====================================================================
* Test 2: Forward/Backward Coupling
* Set VIN1=0.5, VIN2=0.3 (fixed DC).
* Sweep I_err from -0.1u to +1.1u so AT=0 and AT=1u are interior points.
* The difference in V(vout) reveals backward current coupling through
* shared ref3.
* PASS if coupling < 15mV (ref3 sharing effect ~10mV at 1uA/1V).
* =====================================================================
echo ""
echo "============================================"
echo "Test 2: Forward/Backward Coupling"
echo "============================================"
alter Vin1 DC = 0.5
alter Vin2 DC = 0.3
dc I_err -0.1u 1.1u 0.1u
meas DC vout_err0 FIND V(vout) AT=0
meas DC vout_err1u FIND V(vout) AT=1u
echo "V(vout) with I_err=0:"
print vout_err0
echo "V(vout) with I_err=1uA:"
print vout_err1u
let coupling = abs(vout_err1u - vout_err0)
echo "Coupling |delta V(vout)| (expect < 15mV):"
print coupling
if coupling < 0.015
  echo ">>> PASS: Forward/backward coupling < 15mV"
else
  echo ">>> FAIL: Forward/backward coupling >= 15mV"
end

* =====================================================================
* Test 3: Gradient Accuracy
* Sweep I_err, measure gradient current at VIN1.
* Should still be ~6.4e-7 A at I_err=1uA (K * W1_eff).
* PASS if within 5% of 6.4e-7.
* =====================================================================
echo ""
echo "============================================"
echo "Test 3: Gradient Accuracy"
echo "============================================"
alter Vin1 DC = 0
alter @Vin1[sin] = [ 0 0 0 0 0 0 ]
alter Vin2 DC = 0
alter @Vin2[sin] = [ 0 0 0 0 0 0 ]
dc I_err -1.1u 1.1u 0.1u
meas DC ivin1_at0 FIND I(Vin1) AT=0
meas DC ivin1_at1u FIND I(Vin1) AT=1u
meas DC ivin1_atn1u FIND I(Vin1) AT=-1u

let grad1_pos = ivin1_at1u - ivin1_at0
let grad1_neg = ivin1_atn1u - ivin1_at0
let grad_slope1 = (ivin1_at1u - ivin1_atn1u) / 2e-6
echo "Gradient current at I_err=+1uA (expect ~6.4e-7):"
print grad1_pos
echo "Gradient current at I_err=-1uA (expect ~-6.4e-7):"
print grad1_neg
echo "Gradient slope dI(Vin1)/dI_err (expect ~0.64):"
print grad_slope1

let grad_err = abs(grad1_pos - 6.4e-7) / 6.4e-7
echo "Relative error vs 6.4e-7:"
print grad_err
if grad_err < 0.05
  echo ">>> PASS: Gradient accuracy within 5%"
else
  echo ">>> FAIL: Gradient accuracy deviation > 5%"
end

* =====================================================================
* Test 4: Shared Ref3 Operating Point
* Print ref3 voltage. Should be ~2.62V.
* PASS if within 50mV of 2.62V.
* =====================================================================
echo ""
echo "============================================"
echo "Test 4: Shared Ref3 Operating Point"
echo "============================================"
alter Vin1 DC = 0.5
alter Vin2 DC = 0.3
alter I_err DC = 0
op
echo "V(ref3) inside neuron (expect ~2.62V):"
print V(x1.ref3)

let ref3_err = abs(V(x1.ref3) - 2.62)
echo "Deviation from 2.62V:"
print ref3_err
if ref3_err < 0.05
  echo ">>> PASS: ref3 operating point within 50mV of 2.62V"
else
  echo ">>> FAIL: ref3 operating point > 50mV from 2.62V"
end

* =====================================================================
* Test 5: Output Impedance Spot Check
* Apply test current at output, verify Z_out still ~277 ohm.
* PASS if within 10%.
* =====================================================================
echo ""
echo "============================================"
echo "Test 5: Output Impedance"
echo "============================================"
alter Vin1 DC = 0.5
alter @Vin1[sin] = [ 0.5 0 0 0 0 0 ]
alter Vin2 DC = 0.3
alter @Vin2[sin] = [ 0.3 0 0 0 0 0 ]
alter I_err DC = 0
alter I_test DC = 0
alter @I_test[pulse] = [ 0 1m 1m 1n 1n 2m 4m ]
tran 1u 4m UIC
meas TRAN v_before FIND V(vout) AT=0.5m
meas TRAN v_after  FIND V(vout) AT=2m
let z_out = (v_after - v_before) / 1m
echo "Output impedance (expect ~277 ohm):"
print z_out
let z_err = abs(z_out - 277) / 277
echo "Relative error vs 277 ohm:"
print z_err
if z_err < 0.1
  echo ">>> PASS: Z_out within 10% of 277 ohm"
else
  echo ">>> FAIL: Z_out deviation > 10%"
end

echo ""
echo "============================================"
echo "Ref3 sharing validation complete."
echo "============================================"

.endc
.end
