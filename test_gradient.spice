* Gradient Tests (Tests 6, 7)
* Chain rule verification and gradient linearity
* Gradient sign convention: positive gradient = positive current into VIN
* (sinking from upstream output terminal to this input terminal)
* Error enters as current at OUT (I_err), sensed internally via 1M CCVS

.include testbench.spice

.control

set noaskquit

* =====================================================================
* Test 6: Chain Rule — Gradient Current Extraction
* Uses DC sweep of I_err to separate gradient from divider baseline.
* VIN=0 prevents bk_mult from shifting weight nodes.
* =====================================================================
echo ""
echo "============================================"
echo "Test 6: Chain Rule (Gradient Currents)"
echo "============================================"
alter Vin1 DC = 0
alter @Vin1[sin] = [ 0 0 0 0 0 0 ]
alter Vin2 DC = 0
alter @Vin2[sin] = [ 0 0 0 0 0 0 ]

* Sweep I_err beyond -1u..+1u so AT=-1u,0,+1u are interior points
dc I_err -1.1u 1.1u 0.1u
meas DC ivin1_at0 FIND I(Vin1) AT=0
meas DC ivin1_at1u FIND I(Vin1) AT=1u
meas DC ivin1_atn1u FIND I(Vin1) AT=-1u
meas DC ivin2_at0 FIND I(Vin2) AT=0
meas DC ivin2_at1u FIND I(Vin2) AT=1u
meas DC ivin2_atn1u FIND I(Vin2) AT=-1u

echo ""
echo "--- Baseline I(VIN) at I_err=0 (divider loading only) ---"
print ivin1_at0 ivin2_at0

* Pure gradient current = I(I_err=X) - I(I_err=0)
let grad1_pos = ivin1_at1u - ivin1_at0
let grad1_neg = ivin1_atn1u - ivin1_at0
let grad2_pos = ivin2_at1u - ivin2_at0
let grad2_neg = ivin2_atn1u - ivin2_at0

echo ""
echo "--- Pure gradient current (baseline subtracted) ---"
echo "I_err=+1uA: (expect grad1 ~ +6.4e-7, grad2 ~ -3.8e-7)"
print grad1_pos grad2_pos
echo "I_err=-1uA: (expect grad1 ~ -6.4e-7, grad2 ~ +3.8e-7)"
print grad1_neg grad2_neg

echo ""
echo "--- Sign verification ---"
echo "Positive I_err * positive W1 -> positive current INTO VIN1:"
echo "  grad1_pos should be > 0:"
print grad1_pos
echo "Positive I_err * negative W2 -> negative current INTO VIN2:"
echo "  grad2_pos should be < 0:"
print grad2_pos
echo "Negative I_err * positive W1 -> negative current INTO VIN1:"
echo "  grad1_neg should be < 0:"
print grad1_neg
echo "Negative I_err * negative W2 -> positive current INTO VIN2:"
echo "  grad2_neg should be > 0:"
print grad2_neg

echo ""
echo "--- Gradient ratio ---"
let ratio_pos = grad1_pos / grad2_pos
echo "grad1/grad2 at I_err=+1uA (expect W1_eff/W2_eff = -1.75):"
print ratio_pos

* =====================================================================
* Test 7: Gradient Linearity (DC Sweep I_err)
* Slope of I(VIN) vs I_err
* =====================================================================
echo ""
echo "============================================"
echo "Test 7: Gradient Linearity (I_err sweep)"
echo "============================================"

* Reuse the sweep data from test 6
let grad_slope1 = (ivin1_at1u - ivin1_atn1u) / 2e-6
echo "Gradient slope dI(Vin1)/dI_err (expect ~0.64, dimensionless):"
print grad_slope1
let grad_slope2 = (ivin2_at1u - ivin2_atn1u) / 2e-6
echo "Gradient slope dI(Vin2)/dI_err (expect ~-0.36, dimensionless):"
print grad_slope2

echo ""
echo "--- Absolute gradient at I_err=+1uA (expect ~6.4e-7, ~-3.8e-7) ---"
print grad1_pos grad2_pos

echo ""
echo "Gradient tests complete."

.endc
.end
